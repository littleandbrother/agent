Piezo modal two-port, SI force-voltage / velocity-current analogy
Vforce drive 0 SIN(0 0.01174134375 30)
Lmass drive damper 0.0022475
Rdamper damper spring 0.017559653619132
Cspring spring coupling 0.011662396256893
Bcouple coupling sense V=0.00038181492537313*v(piezo)
Vsense sense 0 0
Bpiezo 0 piezo I=0.00038181492537313*i(Vsense)
Cp piezo 0 3.76302982044e-08
XU1 piezo 0 cap vin sw out vin2 0 vin2 pgood 0 LTC3588-1
Cstorage vin 0 150u IC=0
Ccap vin cap 1u
Cvin2 vin2 0 4.7u
L1 sw out 10u Rser=0.4
Cout out 0 68u IC=0 Rser=0.02
Vschedule schedule 0 PWL(0 8e-06 1.9999999 8e-06 2 0.001 2.0099999 0.001 2.01 8e-06 2.0109999 8e-06 2.011 0.008 2.0149999 0.008 2.015 8e-06 5.9999999 8e-06 6 0.001 6.0099999 0.001 6.01 8e-06 6.0109999 8e-06 6.011 0.008 6.0149999 0.008 6.015 8e-06 9.9999999 8e-06 10 0.001 10.0099999 0.001 10.01 8e-06 10.0109999 8e-06 10.011 0.008 10.0149999 0.008 10.015 8e-06 13.9999999 8e-06 14 0.001 14.0099999 0.001 14.01 8e-06 14.0109999 8e-06 14.011 0.008 14.0149999 0.008 14.015 8e-06 20 8e-06)
Bload out 0 I=V(schedule)*limit(V(out)/1.8,0,1)
.lib LTC3588-1.sub
.tran 0 20 0 100u uic
.options plotwinsize=0 reltol=0.001 abstol=1e-12 vntol=1e-8
.save V(piezo) V(vin) V(out) V(pgood) I(Bload)
.meas TRAN output_peak MAX V(out)
.meas TRAN storage_peak MAX V(vin)
.meas TRAN startup WHEN V(out)=2.3 RISE=1
.end
